.title KiCad schematic
R5 Net-_U4-OUTA_ GND 10k
R3 Net-_U3-OUTB_ Net-_U4--INA_ 10k
R4 Net-_U4--INA_ Net-_U4-OUTA_ 10k
R2 Net-_U3-OUTB_ Net-_U3--INB_ 10k
R11 Net-_U3--INA_ Net-_R10-Pad1_ 10k
U3 __U3
V1 Net-_U3-+INA_ GND DC 0 SIN( 0 10 1k )
R12 Net-_R12-Pad1_ Net-_R12-Pad2_ 1k
R7 Vout2b Net-_R12-Pad1_ 3k
R8 Vin2a GND 1k
RV1 Net-_R13-Pad2_ Vin2a Vin2a R_Potentiometer_Trim_US
R13 Net-_R12-Pad2_ Net-_R13-Pad2_ 120
C1 Vin2a GND 10u
R10 Net-_R10-Pad1_ Net-_R10-Pad2_ 10k
R9 Net-_R10-Pad2_ Net-_R1-Pad1_ 10k
U2 __U2
U1 __U1
J3 __J3
R1 Net-_R1-Pad1_ Net-_U3--INB_ 10k
R6 VCC Vin2b 7.5k
U7 __U7
U4 __U4
.end
